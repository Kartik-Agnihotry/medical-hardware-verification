Voltage Divider Verification - EXP003

V1 in 0 DC 5
R1 in out 10k
R2 out 0 1000meg

.op

.end
